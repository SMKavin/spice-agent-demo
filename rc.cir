* RC low-pass filter
V1 in 0 AC 1
R1 in out 10k
C1 out 0 10n
.control
ac dec 100 1 1Meg
meas ac vlow find vm(out) at=10
meas ac f3db when vm(out)=0.7071
.endc
.end
